(setq AxlVars (axlGetVariable nil ))
(setq AxlVars (sort AxlVars nil))
